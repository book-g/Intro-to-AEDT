# Ansys Electronics Desktop project, version 2024.2
materials:
  vacuum: permittivity=1
  Taconic RF-60 (tm): permittivity=6.15 dielectric_loss_tangent=0.0028

design HFSSDesign1 (HFSS, HFSS Modal Network, model units mil)
geometry:
  Box1 [Taconic RF-60 (tm)] = box(corner=(0mil, 0mil, 0mil), size=(1000mil, 148mil, 74mil))
boundaries and excitations:
  Input: Wave Port Faces=Box1.face(-x) WavePortType=Default NumModes=5 Modes{Mode1{CharImp=Zpi} Mode2{CharImp=Zpi} Mode3{CharImp=Zpi} Mode4{CharImp=Zpi} Mode5{CharImp=Zpi}}
  Output: Wave Port Faces=Box1.face(+x) WavePortType=Default NumModes=5 Modes{Mode1{CharImp=Zpi} Mode2{CharImp=Zpi} Mode3{CharImp=Zpi} Mode4{CharImp=Zpi} Mode5{CharImp=Zpi}}
setups:
  Setup1: HfssDriven Frequency=30GHz MaxDeltaS=0.02 MaximumPasses=6 MinimumPasses=1 MinimumConvergedPasses=1 PercentRefinement=30 BasisOrder=1 PortAccuracy=2 DrivenSolverType="Direct Solver"
    sweep Sweep: 15GHz to 45GHz, 10 points; Type=Discrete SaveFields
source amplitudes:
  Input:1: 1W 0deg
  Input:2..Input:5, Output:1..Output:5: 0W 0deg
field plots:
  Mag_E1: E Field in Box1 on Setup1 : LastAdaptive at Freq=30GHz Phase=0deg
  Mag_H1: H Field in Box1 on Setup1 : LastAdaptive at Freq=30GHz Phase=0deg
  Mag_E2: E Field in Box1 on Setup1 : Sweep at Freq=15GHz Phase=0deg
reports:
  Gamma Plot 1: im(Gamma(Input:1)), im(Gamma(Input:2)), im(Gamma(Input:3)), im(Gamma(Input:4)), im(Gamma(Input:5)) vs Freq on Setup1 : Sweep; markers m1 at 15GHz, m2 at 31.666667GHz, m3 at 35GHz
  Gamma Plot 2: re(Gamma(Output:1)), re(Gamma(Output:2)), re(Gamma(Output:3)), re(Gamma(Output:4)), re(Gamma(Output:5)) vs Freq on Setup1 : Sweep; markers m1 at 18.333333GHz, m2 at 35GHz, m3 at 38.333333GHz
