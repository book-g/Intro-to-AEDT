# Ansys Electronics Desktop project, version 2024.2
materials:
  vacuum: permittivity=1
  Taconic RF-60 (tm): permittivity=6.15 dielectric_loss_tangent=0.0028

design HFSSDesign1 (HFSS, HFSS Modal Network, model units mm)
variables:
  length = 15mm
  width = 3.78mm
  height = 1.88mm
geometry:
  Box1 = box(corner=(0mm, 0mm, 0mm), size=(length, width, height))
  twist_cavity = object_from(twist_cavity_SweepFaceAlongNormal1.face(at (15, 1.89, 0.94)))
  Polyline1 = polyline((length, width/2, height/2) (2*length, width/2, height/2))
  twist_cavity.sweep_along_path(Polyline1, twist=-90deg)
  twist_cavity_SweepFaceAlongNormal1 [Taconic RF-60 (tm)] = sweep_along_normal(twist_cavity_SweepFaceAlongNormal1.face(at (30, 1.89, 0.94)), length=length)
  twist_cavity_SweepFaceAlongNormal1.unite(twist_cavity, Box1)
boundaries and excitations:
  Input: Wave Port Faces=twist_cavity_SweepFaceAlongNormal1.face(at (0, 1.89, 0.94)) WavePortType=Default NumModes=5 Modes{Mode1{CharImp=Zpi} Mode2{CharImp=Zpi} Mode3{CharImp=Zpi} Mode4{CharImp=Zpi} Mode5{CharImp=Zpi}}
  Output: Wave Port Faces=twist_cavity_SweepFaceAlongNormal1.face(at (45, 1.89, 0.94)) WavePortType=Default NumModes=5 Modes{Mode1{CharImp=Zpi} Mode2{CharImp=Zpi} Mode3{CharImp=Zpi} Mode4{CharImp=Zpi} Mode5{CharImp=Zpi}}
setups:
  Setup1: HfssDriven Frequency=30GHz MaxDeltaS=0.02 MaximumPasses=6 MinimumPasses=1 MinimumConvergedPasses=1 PercentRefinement=30 BasisOrder=1 PortAccuracy=2 DrivenSolverType="Direct Solver"
    sweep Sweep: 15GHz to 45GHz, 10 points; Type=Discrete SaveFields
source amplitudes:
  Input:1: 1W 0deg
  Input:2..Input:5, Output:1..Output:5: 0W 0deg
field plots:
  Mag_E1: E Field over twist_cavity_SweepFaceAlongNormal1.face(all 14) on Setup1 : LastAdaptive at Freq=30GHz Phase=0deg
reports:
  Gamma Plot 1: im(Gamma(Input:1)), im(Gamma(Input:2)), im(Gamma(Input:3)), im(Gamma(Input:4)), im(Gamma(Input:5)) vs Freq on Setup1 : Sweep
