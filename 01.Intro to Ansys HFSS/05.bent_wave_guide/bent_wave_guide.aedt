# Ansys Electronics Desktop project, version 2024.2
materials:
  vacuum: permittivity=1
  Taconic RF-60 (tm): permittivity=6.15 dielectric_loss_tangent=0.0028

design HFSSDesign1 (HFSS, HFSS Modal Network, model units mm)
variables:
  length = 15mm
  width = 3.76mm
  height = 1.88mm
  bent_radius = 15mm
geometry:
  Box1 [Taconic RF-60 (tm)] = box(corner=(0mm, 0mm, 0mm), size=(length, width, height))
  bent_caviy = object_from(Box1.face(-x))
  coordinate_system RelativeCS1 = origin=(0mm, bent_radius+width, 0mm) x=(1mm, 0mm, 0mm) y=(0mm, 1mm, 0mm)
  bent_caviy.sweep_around_axis(axis=Z, angle=-90deg) in RelativeCS1
  bent_caviy_SweepFaceAlongNormal1 = sweep_along_normal(Box1.face(at (-16.88, 18.76, 0.94)), length=length)
  Box1.unite(bent_caviy_SweepFaceAlongNormal1, bent_caviy)
boundaries and excitations:
  Input: Wave Port Faces=Box1.face(+x) WavePortType=Default NumModes=5 Modes{Mode1{CharImp=Zpi} Mode2{CharImp=Zpi} Mode3{CharImp=Zpi} Mode4{CharImp=Zpi} Mode5{CharImp=Zpi}}
  Output: Wave Port Faces=Box1.face(at (-16.88, 33.76, 0.94)) WavePortType=Default NumModes=5 Modes{Mode1{CharImp=Zpi} Mode2{CharImp=Zpi} Mode3{CharImp=Zpi} Mode4{CharImp=Zpi} Mode5{CharImp=Zpi}}
setups:
  Setup1: HfssDriven Frequency=30GHz MaxDeltaS=0.02 MaximumPasses=6 MinimumPasses=1 MinimumConvergedPasses=1 PercentRefinement=30 BasisOrder=1 PortAccuracy=2 DrivenSolverType="Direct Solver"
    sweep Sweep: 15GHz to 45GHz, 10 points; Type=Discrete SaveFields
source amplitudes:
  Input:1: 1W 0deg
  Input:2..Input:5, Output:1..Output:5: 0W 0deg
field plots:
  Mag_E1: E Field in Box1 on Setup1 : LastAdaptive at Freq=30GHz Phase=0deg
